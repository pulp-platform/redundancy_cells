{
  name: "ECC_manager",
  clock_primary: "clk_i",
  reset_primary: "rst_ni",
  bus_interfaces: [
    { protocol: "reg_iface",
      direction: "device"
    }
  ],

  regwidth: "32",

  param_list: [ 
  { name:   "NumBanks",
      default: "6"
  }
  ],
  registers: [
    { multireg: 
      { count: "NumBanks",
        cname: "mismatch_count",
        name: "mismatch_count",
        desc: "Correctable mismatches caught by ecc",
        swaccess: "rw0c",
        hwaccess: "hrw",
        resval: "0",
        fields: [
          { bits: "31:0",
            name: "correctable_mismatches",
            desc: "Correctable mismatches caught by ecc"
          }
        ]
      }
    }
  ],
}
