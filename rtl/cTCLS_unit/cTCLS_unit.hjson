{
  name: "cTCLS_manager",
  clock_primary: "clk_i",
  reset_primary: "rst_ni",
  bus_device: "reg",
  bus_host: "",

  regwidth: "32",
  registers: [
    { name: "MODE",
      desc: "Redundancy Mode configuration",
      swaccess: "wo",
      hwaccess: "hro",
      fields: [
        { bits: "0",
          name: "MODE",
          desc: "TMR mode enable"
        },
        { bits: "8",
          name: "RESTORE_MODE",
          desc: "Enable wait-for-restoration"
        }
      ]
    },
    { name: "MISMATCHES_0",
      desc: "Mismatches of core 0",
      swaccess: "rw0c",
      hwaccess: "hrw",
      fields: [
        { bits: "31:0",
          name: "mismatches_0",
          desc: "mismatches of core 0"
        }
      ]
    },
    { name: "MISMATCHES_1",
      desc: "Mismatches of core 1",
      swaccess: "rw0c",
      hwaccess: "hrw",
      fields: [
        { bits: "31:0",
          name: "mismatches_1",
          desc: "mismatches of core 1"
        }
      ]
    },
    { name: "MISMATCHES_2",
      desc: "Mismatches of core 2",
      swaccess: "rw0c",
      hwaccess: "hrw",
      fields: [
        { bits: "31:0",
          name: "mismatches_2",
          desc: "mismatches of core 2"
        }
      ]
    }
  ],
}
